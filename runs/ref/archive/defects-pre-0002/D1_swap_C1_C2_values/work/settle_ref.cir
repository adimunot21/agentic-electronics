* test bench (generated)
.include settle_ref_dut.cir
Vcc P5V 0 DC 5.0
Vref VREF 0 DC 3.3
Vsrc src 0 DC 0 SIN(0 1.0 1000)
Rs src AIN 100.0
.control
tran 1u 4.5m 0 1u
wrdata ref.csv v(aout)
.endc
.end
