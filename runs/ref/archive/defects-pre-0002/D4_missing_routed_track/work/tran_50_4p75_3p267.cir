* test bench (generated)
.include tran_50_4p75_3p267_dut.cir
Vcc P5V 0 DC 4.75
Vref VREF 0 DC 3.267
Vsrc src 0 DC 0 SIN(0 1.0 50)
Rs src AIN 100.0
.control
tran 2e-05 0.12 0 2e-05
wrdata tran_50_4p75_3p267.csv v(aout)
.endc
.end
