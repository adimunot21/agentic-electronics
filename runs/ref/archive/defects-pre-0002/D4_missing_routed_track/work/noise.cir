* test bench (generated)
.include noise_dut.cir
Vcc P5V 0 DC 5.0
Vref VREF 0 DC 3.3
Vsrc src 0 DC 0 AC 1
Rs src AIN 100.0
.control
noise v(aout) Vsrc dec 20 1 20k
print onoise_total
.endc
.end
