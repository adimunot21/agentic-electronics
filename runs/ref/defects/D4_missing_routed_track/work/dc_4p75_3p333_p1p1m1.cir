* test bench (generated)
.include dc_4p75_3p333_p1p1m1_dut.cir
Vcc P5V 0 DC 4.75
Vref VREF 0 DC 3.333
Vsrc src 0 DC 0
Rs src AIN 100.0
.control
op
print v(aout) i(vcc)
.endc
.end
