* test bench (generated)
.include tran_1000_4p75_3p333_dut.cir
Vcc P5V 0 DC 4.75
Vref VREF 0 DC 3.333
Vsrc src 0 DC 0 SIN(0 1.0 1000)
Rs src AIN 100.0
.control
tran 2e-06 0.008 0 2e-06
wrdata tran_1000_4p75_3p333.csv v(aout)
.endc
.end
