* test bench (generated)
.include st_ideal_dut.cir
Vcc P5V 0 DC 5.0
Vref VREF 0 DC 3.3
Vsrc src 0 DC 0 PULSE(0 0.2 0.0001 1n 1n 1)
Rs src AIN 100.0
.control
tran 1u 0.004 0 1u
wrdata st_ideal.csv v(aout)
.endc
.end
