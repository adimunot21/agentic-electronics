* test bench (generated)
.include lg_stage2_1_dut.cir
Vcc P5V 0 DC 5.0
Vref VREF 0 DC 3.3
Vsrc src 0 DC 0
Rs src AIN 100.0
.control
op
ac dec 50 10 100Meg
wrdata lg_stage2_1.csv v(N_S2) v(N_S2F)
.endc
.end
