* DUT deck generated from KiCad netlist (do not edit; regenerate)
.include opa2314_ngspice_shim.lib
C1 X 0 18n
C2 N_INV N_S1 1n
C3 N_INV2 N_S2 5.6n
C4 AIN N_IN 2.2u
C5 AOUT 0 330p
C6 VMID 0 10u
C7 P5V 0 10u
C8 P5V 0 100n
R1 N_IN X 59k
R2 X N_S1 76.8k
R3 X N_INV 6.19k
R4 N_S1 N_INV2 16.5k
R5 N_INV2 N_S2 16.5k
R6 N_S2 AOUT 475
R7 VREF VMID 10k
R8 VMID 0 10k
EU1A N_S1 0 VMID N_INV 1e6
EU1B N_S2 0 VMID N_INV2 1e6
